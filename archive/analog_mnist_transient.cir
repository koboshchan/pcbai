* 7-PCB DISCRETE ANALOG NEURAL NETWORK FOR MNIST INFERENCE
* Full Transistor / Macromodel SPICE Netlist

* =====================================================================
* COMPONENT MODELS & SUBCIRCUITS
* =====================================================================
.model 1N4148 D (Is=2.52n Rs=0.568 N=1.752 Cjo=4p M=0.4 tt=20n)
.model LED_GREEN D (Is=1e-15 N=1.8 Rs=15 Eg=2.2 Cjo=15p)

* TL074 Op-Amp Behavioral Macromodel (GBW=3MHz, SR=13V/us, Iin=30pA, Vsat=+/-10.5V)
.subckt TL074 in_pos in_neg out vcc vee
Rin in_pos in_neg 1e11
Cin in_pos in_neg 3p
* Slew-rate limited differential transconductance stage (SR = 13V/us on 30pF)
B_gm 0 int_node I = 390u * tanh((v(in_pos) - v(in_neg)) * 2.56)
R1 int_node 0 2.56e8
C1 int_node 0 30p
* Anti-windup rail clamps on internal integrator node
D_CP int_node v_cp 1N4148
V_CP v_cp 0 10.5
D_CN v_cn int_node 1N4148
V_CN v_cn 0 -10.5
* Rail saturation clipping at +/- 10.5V
B_out out_raw 0 V = 10.5 * tanh(v(int_node) / 10.5)
Rout out_raw out 50
.ends TL074

* LM339 Open-Collector Quad Comparator Macromodel
.subckt LM339 in_pos in_neg out vcc vee
Rin in_pos in_neg 1e9
* Open-collector switch pulling to ground when in_neg > in_pos
B_comp out_sw 0 V = 0.5 + 0.5 * tanh(100.0 * (v(in_neg) - v(in_pos)))
S1 out 0 out_sw 0 SW_LM339
.model SW_LM339 SW (Ron=25 Roff=1e7 Vt=0.5 Vh=0.05)
.ends LM339

* =====================================================================
* POWER RAILS
* =====================================================================
V_VCC vcc 0 12.0
V_VEE vee 0 -12.0
V_POS5 ref_pos5 0 5.0
V_NEG5 ref_neg5 0 -5.0
V_LED v_led 0 5.0

* =====================================================================
* MOTHERBOARD: 64 DUAL-RAIL INPUT VOLTAGES (+/- Vin)
* =====================================================================
V_IN_0 in_0_p 0 PULSE(0.0 0.0000 1.0u 10n 10n 50u 100u)
E_INV_0 in_0_n 0 in_0_p 0 -1.0
R_INV_0 in_0_n 0 100k
V_IN_1 in_1_p 0 PULSE(0.0 0.0000 1.0u 10n 10n 50u 100u)
E_INV_1 in_1_n 0 in_1_p 0 -1.0
R_INV_1 in_1_n 0 100k
V_IN_2 in_2_p 0 PULSE(0.0 0.3100 1.0u 10n 10n 50u 100u)
E_INV_2 in_2_n 0 in_2_p 0 -1.0
R_INV_2 in_2_n 0 100k
V_IN_3 in_3_p 0 PULSE(0.0 3.7500 1.0u 10n 10n 50u 100u)
E_INV_3 in_3_n 0 in_3_p 0 -1.0
R_INV_3 in_3_n 0 100k
V_IN_4 in_4_p 0 PULSE(0.0 1.5600 1.0u 10n 10n 50u 100u)
E_INV_4 in_4_n 0 in_4_p 0 -1.0
R_INV_4 in_4_n 0 100k
V_IN_5 in_5_p 0 PULSE(0.0 0.0000 1.0u 10n 10n 50u 100u)
E_INV_5 in_5_n 0 in_5_p 0 -1.0
R_INV_5 in_5_n 0 100k
V_IN_6 in_6_p 0 PULSE(0.0 0.0000 1.0u 10n 10n 50u 100u)
E_INV_6 in_6_n 0 in_6_p 0 -1.0
R_INV_6 in_6_n 0 100k
V_IN_7 in_7_p 0 PULSE(0.0 0.0000 1.0u 10n 10n 50u 100u)
E_INV_7 in_7_n 0 in_7_p 0 -1.0
R_INV_7 in_7_n 0 100k
V_IN_8 in_8_p 0 PULSE(0.0 0.0000 1.0u 10n 10n 50u 100u)
E_INV_8 in_8_n 0 in_8_p 0 -1.0
R_INV_8 in_8_n 0 100k
V_IN_9 in_9_p 0 PULSE(0.0 0.0000 1.0u 10n 10n 50u 100u)
E_INV_9 in_9_n 0 in_9_p 0 -1.0
R_INV_9 in_9_n 0 100k
V_IN_10 in_10_p 0 PULSE(0.0 2.8100 1.0u 10n 10n 50u 100u)
E_INV_10 in_10_n 0 in_10_p 0 -1.0
R_INV_10 in_10_n 0 100k
V_IN_11 in_11_p 0 PULSE(0.0 5.0000 1.0u 10n 10n 50u 100u)
E_INV_11 in_11_n 0 in_11_p 0 -1.0
R_INV_11 in_11_n 0 100k
V_IN_12 in_12_p 0 PULSE(0.0 4.3800 1.0u 10n 10n 50u 100u)
E_INV_12 in_12_n 0 in_12_p 0 -1.0
R_INV_12 in_12_n 0 100k
V_IN_13 in_13_p 0 PULSE(0.0 0.9400 1.0u 10n 10n 50u 100u)
E_INV_13 in_13_n 0 in_13_p 0 -1.0
R_INV_13 in_13_n 0 100k
V_IN_14 in_14_p 0 PULSE(0.0 0.0000 1.0u 10n 10n 50u 100u)
E_INV_14 in_14_n 0 in_14_p 0 -1.0
R_INV_14 in_14_n 0 100k
V_IN_15 in_15_p 0 PULSE(0.0 0.0000 1.0u 10n 10n 50u 100u)
E_INV_15 in_15_n 0 in_15_p 0 -1.0
R_INV_15 in_15_n 0 100k
V_IN_16 in_16_p 0 PULSE(0.0 0.0000 1.0u 10n 10n 50u 100u)
E_INV_16 in_16_n 0 in_16_p 0 -1.0
R_INV_16 in_16_n 0 100k
V_IN_17 in_17_p 0 PULSE(0.0 0.6200 1.0u 10n 10n 50u 100u)
E_INV_17 in_17_n 0 in_17_p 0 -1.0
R_INV_17 in_17_n 0 100k
V_IN_18 in_18_p 0 PULSE(0.0 5.0000 1.0u 10n 10n 50u 100u)
E_INV_18 in_18_n 0 in_18_p 0 -1.0
R_INV_18 in_18_n 0 100k
V_IN_19 in_19_p 0 PULSE(0.0 4.3800 1.0u 10n 10n 50u 100u)
E_INV_19 in_19_n 0 in_19_p 0 -1.0
R_INV_19 in_19_n 0 100k
V_IN_20 in_20_p 0 PULSE(0.0 3.4400 1.0u 10n 10n 50u 100u)
E_INV_20 in_20_n 0 in_20_p 0 -1.0
R_INV_20 in_20_n 0 100k
V_IN_21 in_21_p 0 PULSE(0.0 4.0600 1.0u 10n 10n 50u 100u)
E_INV_21 in_21_n 0 in_21_p 0 -1.0
R_INV_21 in_21_n 0 100k
V_IN_22 in_22_p 0 PULSE(0.0 0.0000 1.0u 10n 10n 50u 100u)
E_INV_22 in_22_n 0 in_22_p 0 -1.0
R_INV_22 in_22_n 0 100k
V_IN_23 in_23_p 0 PULSE(0.0 0.0000 1.0u 10n 10n 50u 100u)
E_INV_23 in_23_n 0 in_23_p 0 -1.0
R_INV_23 in_23_n 0 100k
V_IN_24 in_24_p 0 PULSE(0.0 0.0000 1.0u 10n 10n 50u 100u)
E_INV_24 in_24_n 0 in_24_p 0 -1.0
R_INV_24 in_24_n 0 100k
V_IN_25 in_25_p 0 PULSE(0.0 0.6200 1.0u 10n 10n 50u 100u)
E_INV_25 in_25_n 0 in_25_p 0 -1.0
R_INV_25 in_25_n 0 100k
V_IN_26 in_26_p 0 PULSE(0.0 5.0000 1.0u 10n 10n 50u 100u)
E_INV_26 in_26_n 0 in_26_p 0 -1.0
R_INV_26 in_26_n 0 100k
V_IN_27 in_27_p 0 PULSE(0.0 3.1200 1.0u 10n 10n 50u 100u)
E_INV_27 in_27_n 0 in_27_p 0 -1.0
R_INV_27 in_27_n 0 100k
V_IN_28 in_28_p 0 PULSE(0.0 0.0000 1.0u 10n 10n 50u 100u)
E_INV_28 in_28_n 0 in_28_p 0 -1.0
R_INV_28 in_28_n 0 100k
V_IN_29 in_29_p 0 PULSE(0.0 4.3800 1.0u 10n 10n 50u 100u)
E_INV_29 in_29_n 0 in_29_p 0 -1.0
R_INV_29 in_29_n 0 100k
V_IN_30 in_30_p 0 PULSE(0.0 1.2500 1.0u 10n 10n 50u 100u)
E_INV_30 in_30_n 0 in_30_p 0 -1.0
R_INV_30 in_30_n 0 100k
V_IN_31 in_31_p 0 PULSE(0.0 0.0000 1.0u 10n 10n 50u 100u)
E_INV_31 in_31_n 0 in_31_p 0 -1.0
R_INV_31 in_31_n 0 100k
V_IN_32 in_32_p 0 PULSE(0.0 0.0000 1.0u 10n 10n 50u 100u)
E_INV_32 in_32_n 0 in_32_p 0 -1.0
R_INV_32 in_32_n 0 100k
V_IN_33 in_33_p 0 PULSE(0.0 1.2500 1.0u 10n 10n 50u 100u)
E_INV_33 in_33_n 0 in_33_p 0 -1.0
R_INV_33 in_33_n 0 100k
V_IN_34 in_34_p 0 PULSE(0.0 5.0000 1.0u 10n 10n 50u 100u)
E_INV_34 in_34_n 0 in_34_p 0 -1.0
R_INV_34 in_34_n 0 100k
V_IN_35 in_35_p 0 PULSE(0.0 0.0000 1.0u 10n 10n 50u 100u)
E_INV_35 in_35_n 0 in_35_p 0 -1.0
R_INV_35 in_35_n 0 100k
V_IN_36 in_36_p 0 PULSE(0.0 0.0000 1.0u 10n 10n 50u 100u)
E_INV_36 in_36_n 0 in_36_p 0 -1.0
R_INV_36 in_36_n 0 100k
V_IN_37 in_37_p 0 PULSE(0.0 3.7500 1.0u 10n 10n 50u 100u)
E_INV_37 in_37_n 0 in_37_p 0 -1.0
R_INV_37 in_37_n 0 100k
V_IN_38 in_38_p 0 PULSE(0.0 1.2500 1.0u 10n 10n 50u 100u)
E_INV_38 in_38_n 0 in_38_p 0 -1.0
R_INV_38 in_38_n 0 100k
V_IN_39 in_39_p 0 PULSE(0.0 0.0000 1.0u 10n 10n 50u 100u)
E_INV_39 in_39_n 0 in_39_p 0 -1.0
R_INV_39 in_39_n 0 100k
V_IN_40 in_40_p 0 PULSE(0.0 0.0000 1.0u 10n 10n 50u 100u)
E_INV_40 in_40_n 0 in_40_p 0 -1.0
R_INV_40 in_40_n 0 100k
V_IN_41 in_41_p 0 PULSE(0.0 1.2500 1.0u 10n 10n 50u 100u)
E_INV_41 in_41_n 0 in_41_p 0 -1.0
R_INV_41 in_41_n 0 100k
V_IN_42 in_42_p 0 PULSE(0.0 5.0000 1.0u 10n 10n 50u 100u)
E_INV_42 in_42_n 0 in_42_p 0 -1.0
R_INV_42 in_42_n 0 100k
V_IN_43 in_43_p 0 PULSE(0.0 0.9400 1.0u 10n 10n 50u 100u)
E_INV_43 in_43_n 0 in_43_p 0 -1.0
R_INV_43 in_43_n 0 100k
V_IN_44 in_44_p 0 PULSE(0.0 0.0000 1.0u 10n 10n 50u 100u)
E_INV_44 in_44_n 0 in_44_p 0 -1.0
R_INV_44 in_44_n 0 100k
V_IN_45 in_45_p 0 PULSE(0.0 3.4400 1.0u 10n 10n 50u 100u)
E_INV_45 in_45_n 0 in_45_p 0 -1.0
R_INV_45 in_45_n 0 100k
V_IN_46 in_46_p 0 PULSE(0.0 3.1200 1.0u 10n 10n 50u 100u)
E_INV_46 in_46_n 0 in_46_p 0 -1.0
R_INV_46 in_46_n 0 100k
V_IN_47 in_47_p 0 PULSE(0.0 0.0000 1.0u 10n 10n 50u 100u)
E_INV_47 in_47_n 0 in_47_p 0 -1.0
R_INV_47 in_47_n 0 100k
V_IN_48 in_48_p 0 PULSE(0.0 0.0000 1.0u 10n 10n 50u 100u)
E_INV_48 in_48_n 0 in_48_p 0 -1.0
R_INV_48 in_48_n 0 100k
V_IN_49 in_49_p 0 PULSE(0.0 0.0000 1.0u 10n 10n 50u 100u)
E_INV_49 in_49_n 0 in_49_p 0 -1.0
R_INV_49 in_49_n 0 100k
V_IN_50 in_50_p 0 PULSE(0.0 4.0600 1.0u 10n 10n 50u 100u)
E_INV_50 in_50_n 0 in_50_p 0 -1.0
R_INV_50 in_50_n 0 100k
V_IN_51 in_51_p 0 PULSE(0.0 3.7500 1.0u 10n 10n 50u 100u)
E_INV_51 in_51_n 0 in_51_p 0 -1.0
R_INV_51 in_51_n 0 100k
V_IN_52 in_52_p 0 PULSE(0.0 2.5000 1.0u 10n 10n 50u 100u)
E_INV_52 in_52_n 0 in_52_p 0 -1.0
R_INV_52 in_52_n 0 100k
V_IN_53 in_53_p 0 PULSE(0.0 4.3800 1.0u 10n 10n 50u 100u)
E_INV_53 in_53_n 0 in_53_p 0 -1.0
R_INV_53 in_53_n 0 100k
V_IN_54 in_54_p 0 PULSE(0.0 1.8800 1.0u 10n 10n 50u 100u)
E_INV_54 in_54_n 0 in_54_p 0 -1.0
R_INV_54 in_54_n 0 100k
V_IN_55 in_55_p 0 PULSE(0.0 0.0000 1.0u 10n 10n 50u 100u)
E_INV_55 in_55_n 0 in_55_p 0 -1.0
R_INV_55 in_55_n 0 100k
V_IN_56 in_56_p 0 PULSE(0.0 0.0000 1.0u 10n 10n 50u 100u)
E_INV_56 in_56_n 0 in_56_p 0 -1.0
R_INV_56 in_56_n 0 100k
V_IN_57 in_57_p 0 PULSE(0.0 0.0000 1.0u 10n 10n 50u 100u)
E_INV_57 in_57_n 0 in_57_p 0 -1.0
R_INV_57 in_57_n 0 100k
V_IN_58 in_58_p 0 PULSE(0.0 0.9400 1.0u 10n 10n 50u 100u)
E_INV_58 in_58_n 0 in_58_p 0 -1.0
R_INV_58 in_58_n 0 100k
V_IN_59 in_59_p 0 PULSE(0.0 3.1200 1.0u 10n 10n 50u 100u)
E_INV_59 in_59_n 0 in_59_p 0 -1.0
R_INV_59 in_59_n 0 100k
V_IN_60 in_60_p 0 PULSE(0.0 5.0000 1.0u 10n 10n 50u 100u)
E_INV_60 in_60_n 0 in_60_p 0 -1.0
R_INV_60 in_60_n 0 100k
V_IN_61 in_61_p 0 PULSE(0.0 3.7500 1.0u 10n 10n 50u 100u)
E_INV_61 in_61_n 0 in_61_p 0 -1.0
R_INV_61 in_61_n 0 100k
V_IN_62 in_62_p 0 PULSE(0.0 0.3100 1.0u 10n 10n 50u 100u)
E_INV_62 in_62_n 0 in_62_p 0 -1.0
R_INV_62 in_62_n 0 100k
V_IN_63 in_63_p 0 PULSE(0.0 0.0000 1.0u 10n 10n 50u 100u)
E_INV_63 in_63_n 0 in_63_p 0 -1.0
R_INV_63 in_63_n 0 100k

* =====================================================================
* LAYER 1: 16 NEURON SUMMING AMPLIFIERS (DC1A..DC1D)
* =====================================================================
X_L1_0 0 sum1_0 v_sum1_0 vcc vee TL074
Rf_L1_0 sum1_0 v_sum1_0 10.0k
Cf_L1_0 sum1_0 v_sum1_0 5.0p
Rb_L1_0 ref_pos5 sum1_0 324000.00
R1_1_0 in_1_n sum1_0 34000.00
R1_2_0 in_2_n sum1_0 20500.00
R1_3_0 in_3_p sum1_0 54900.00
R1_4_0 in_4_p sum1_0 37400.00
R1_5_0 in_5_n sum1_0 20500.00
R1_6_0 in_6_n sum1_0 10000.00
R1_7_0 in_7_n sum1_0 24900.00
R1_8_0 in_8_n sum1_0 9760000.00
R1_9_0 in_9_p sum1_0 15400.00
R1_10_0 in_10_p sum1_0 64900.00
R1_11_0 in_11_p sum1_0 71500.00
R1_12_0 in_12_p sum1_0 41200.00
R1_13_0 in_13_p sum1_0 22600.00
R1_14_0 in_14_p sum1_0 90900.00
R1_15_0 in_15_n sum1_0 178000.00
R1_16_0 in_16_n sum1_0 68100.00
R1_17_0 in_17_p sum1_0 69800.00
R1_18_0 in_18_p sum1_0 82500.00
R1_19_0 in_19_n sum1_0 28000.00
R1_20_0 in_20_p sum1_0 12100.00
R1_21_0 in_21_p sum1_0 8450.00
R1_22_0 in_22_p sum1_0 11000.00
R1_23_0 in_23_n sum1_0 130000.00
R1_24_0 in_24_n sum1_0 162000.00
R1_25_0 in_25_n sum1_0 45300.00
R1_26_0 in_26_n sum1_0 26700.00
R1_27_0 in_27_n sum1_0 64900.00
R1_28_0 in_28_n sum1_0 14300.00
R1_29_0 in_29_p sum1_0 69800.00
R1_30_0 in_30_n sum1_0 100000.00
R1_33_0 in_33_n sum1_0 9090.00
R1_34_0 in_34_n sum1_0 43200.00
R1_35_0 in_35_p sum1_0 182000.00
R1_36_0 in_36_n sum1_0 14300.00
R1_37_0 in_37_n sum1_0 29400.00
R1_38_0 in_38_n sum1_0 16900.00
R1_41_0 in_41_n sum1_0 23700.00
R1_42_0 in_42_p sum1_0 66500.00
R1_43_0 in_43_n sum1_0 13300.00
R1_44_0 in_44_n sum1_0 14700.00
R1_45_0 in_45_n sum1_0 48700.00
R1_46_0 in_46_p sum1_0 30100.00
R1_47_0 in_47_p sum1_0 787000.00
R1_48_0 in_48_p sum1_0 750000.00
R1_49_0 in_49_p sum1_0 34800.00
R1_50_0 in_50_p sum1_0 105000.00
R1_51_0 in_51_n sum1_0 34000.00
R1_52_0 in_52_p sum1_0 97600.00
R1_53_0 in_53_p sum1_0 19100.00
R1_54_0 in_54_p sum1_0 11300.00
R1_55_0 in_55_n sum1_0 10700.00
R1_56_0 in_56_p sum1_0 2050000.00
R1_57_0 in_57_p sum1_0 57600.00
R1_58_0 in_58_n sum1_0 51100.00
R1_59_0 in_59_n sum1_0 52300.00
R1_60_0 in_60_n sum1_0 158000.00
R1_61_0 in_61_p sum1_0 165000.00
R1_62_0 in_62_p sum1_0 54900.00
R1_63_0 in_63_n sum1_0 14700.00
X_L1_1 0 sum1_1 v_sum1_1 vcc vee TL074
Rf_L1_1 sum1_1 v_sum1_1 10.0k
Cf_L1_1 sum1_1 v_sum1_1 5.0p
Rb_L1_1 ref_neg5 sum1_1 332000.00
R1_1_1 in_1_n sum1_1 105000.00
R1_2_1 in_2_p sum1_1 20500.00
R1_3_1 in_3_p sum1_1 19600.00
R1_4_1 in_4_n sum1_1 21500.00
R1_5_1 in_5_p sum1_1 51100.00
R1_6_1 in_6_p sum1_1 16900.00
R1_7_1 in_7_n sum1_1 2150000.00
R1_9_1 in_9_p sum1_1 15000.00
R1_10_1 in_10_p sum1_1 14700.00
R1_11_1 in_11_p sum1_1 54900.00
R1_12_1 in_12_n sum1_1 143000.00
R1_13_1 in_13_p sum1_1 23200.00
R1_14_1 in_14_p sum1_1 17800.00
R1_15_1 in_15_n sum1_1 3010000.00
R1_17_1 in_17_n sum1_1 19600.00
R1_18_1 in_18_p sum1_1 56200.00
R1_19_1 in_19_n sum1_1 15800.00
R1_20_1 in_20_p sum1_1 29400.00
R1_21_1 in_21_p sum1_1 9760.00
R1_22_1 in_22_p sum1_1 97600.00
R1_23_1 in_23_n sum1_1 9760000.00
R1_24_1 in_24_n sum1_1 953000.00
R1_25_1 in_25_n sum1_1 14700.00
R1_26_1 in_26_n sum1_1 26700.00
R1_27_1 in_27_p sum1_1 23700.00
R1_28_1 in_28_p sum1_1 14000.00
R1_29_1 in_29_p sum1_1 21500.00
R1_30_1 in_30_n sum1_1 27400.00
R1_33_1 in_33_n sum1_1 9310.00
R1_34_1 in_34_n sum1_1 40200.00
R1_35_1 in_35_p sum1_1 14700.00
R1_36_1 in_36_p sum1_1 49900.00
R1_37_1 in_37_n sum1_1 11800.00
R1_38_1 in_38_n sum1_1 8870.00
R1_41_1 in_41_n sum1_1 12400.00
R1_42_1 in_42_n sum1_1 15400.00
R1_43_1 in_43_p sum1_1 34800.00
R1_44_1 in_44_n sum1_1 16200.00
R1_45_1 in_45_n sum1_1 9530.00
R1_46_1 in_46_n sum1_1 12100.00
R1_47_1 in_47_n sum1_1 210000.00
R1_48_1 in_48_p sum1_1 9760000.00
R1_49_1 in_49_n sum1_1 52300.00
R1_50_1 in_50_n sum1_1 15400.00
R1_51_1 in_51_p sum1_1 44200.00
R1_52_1 in_52_n sum1_1 14700.00
R1_53_1 in_53_n sum1_1 26700.00
R1_54_1 in_54_p sum1_1 294000.00
R1_55_1 in_55_p sum1_1 121000.00
R1_56_1 in_56_p sum1_1 9760000.00
R1_57_1 in_57_p sum1_1 845000.00
R1_58_1 in_58_p sum1_1 57600.00
R1_59_1 in_59_p sum1_1 23700.00
R1_60_1 in_60_n sum1_1 22100.00
R1_61_1 in_61_n sum1_1 30900.00
R1_62_1 in_62_p sum1_1 22100.00
R1_63_1 in_63_p sum1_1 69800.00
X_L1_2 0 sum1_2 v_sum1_2 vcc vee TL074
Rf_L1_2 sum1_2 v_sum1_2 10.0k
Cf_L1_2 sum1_2 v_sum1_2 5.0p
Rb_L1_2 ref_pos5 sum1_2 140000.00
R1_1_2 in_1_n sum1_2 24300.00
R1_2_2 in_2_n sum1_2 30900.00
R1_3_2 in_3_n sum1_2 137000.00
R1_4_2 in_4_p sum1_2 20000.00
R1_5_2 in_5_n sum1_2 41200.00
R1_6_2 in_6_n sum1_2 60400.00
R1_7_2 in_7_p sum1_2 22600.00
R1_8_2 in_8_p sum1_2 9760000.00
R1_9_2 in_9_n sum1_2 17800.00
R1_10_2 in_10_p sum1_2 40200.00
R1_11_2 in_11_p sum1_2 64900.00
R1_12_2 in_12_p sum1_2 255000.00
R1_13_2 in_13_p sum1_2 15400.00
R1_14_2 in_14_p sum1_2 23200.00
R1_15_2 in_15_p sum1_2 40200.00
R1_16_2 in_16_n sum1_2 150000.00
R1_17_2 in_17_n sum1_2 29400.00
R1_18_2 in_18_n sum1_2 52300.00
R1_19_2 in_19_n sum1_2 17400.00
R1_20_2 in_20_p sum1_2 1070000.00
R1_21_2 in_21_p sum1_2 22600.00
R1_22_2 in_22_p sum1_2 12100.00
R1_23_2 in_23_p sum1_2 9760000.00
R1_24_2 in_24_n sum1_2 511000.00
R1_25_2 in_25_n sum1_2 14300.00
R1_26_2 in_26_n sum1_2 42200.00
R1_27_2 in_27_n sum1_2 54900.00
R1_28_2 in_28_n sum1_2 110000.00
R1_29_2 in_29_p sum1_2 90900.00
R1_30_2 in_30_p sum1_2 13700.00
R1_33_2 in_33_p sum1_2 34000.00
R1_34_2 in_34_p sum1_2 84500.00
R1_35_2 in_35_p sum1_2 46400.00
R1_36_2 in_36_p sum1_2 45300.00
R1_37_2 in_37_p sum1_2 46400.00
R1_38_2 in_38_p sum1_2 19600.00
R1_41_2 in_41_p sum1_2 20000.00
R1_42_2 in_42_p sum1_2 37400.00
R1_43_2 in_43_n sum1_2 68100.00
R1_44_2 in_44_p sum1_2 21500.00
R1_45_2 in_45_p sum1_2 13300.00
R1_46_2 in_46_p sum1_2 18700.00
R1_47_2 in_47_p sum1_2 3090000.00
R1_48_2 in_48_n sum1_2 845000.00
R1_49_2 in_49_n sum1_2 57600.00
R1_50_2 in_50_p sum1_2 60400.00
R1_51_2 in_51_n sum1_2 49900.00
R1_52_2 in_52_n sum1_2 18200.00
R1_53_2 in_53_n sum1_2 18200.00
R1_54_2 in_54_n sum1_2 66500.00
R1_55_2 in_55_n sum1_2 75000.00
R1_56_2 in_56_n sum1_2 2740000.00
R1_57_2 in_57_n sum1_2 17800.00
R1_58_2 in_58_n sum1_2 28000.00
R1_59_2 in_59_n sum1_2 681000.00
R1_60_2 in_60_n sum1_2 42200.00
R1_61_2 in_61_n sum1_2 16500.00
R1_62_2 in_62_n sum1_2 20000.00
R1_63_2 in_63_n sum1_2 71500.00
X_L1_3 0 sum1_3 v_sum1_3 vcc vee TL074
Rf_L1_3 sum1_3 v_sum1_3 10.0k
Cf_L1_3 sum1_3 v_sum1_3 5.0p
Rb_L1_3 ref_pos5 sum1_3 549000.00
R1_6_3 in_6_p sum1_3 9760000.00
R1_11_3 in_11_n sum1_3 9760000.00
R1_14_3 in_14_p sum1_3 9760000.00
X_L1_4 0 sum1_4 v_sum1_4 vcc vee TL074
Rf_L1_4 sum1_4 v_sum1_4 10.0k
Cf_L1_4 sum1_4 v_sum1_4 5.0p
Rb_L1_4 ref_pos5 sum1_4 487000.00
R1_1_4 in_1_p sum1_4 21500.00
R1_2_4 in_2_p sum1_4 34800.00
R1_3_4 in_3_n sum1_4 26700.00
R1_4_4 in_4_p sum1_4 60400.00
R1_5_4 in_5_n sum1_4 53600.00
R1_6_4 in_6_p sum1_4 90900.00
R1_7_4 in_7_p sum1_4 30900.00
R1_8_4 in_8_n sum1_4 3740000.00
R1_9_4 in_9_p sum1_4 23700.00
R1_10_4 in_10_p sum1_4 41200.00
R1_11_4 in_11_p sum1_4 30100.00
R1_12_4 in_12_n sum1_4 84500.00
R1_13_4 in_13_n sum1_4 18700.00
R1_14_4 in_14_p sum1_4 47500.00
R1_15_4 in_15_p sum1_4 80600.00
R1_16_4 in_16_n sum1_4 64900.00
R1_17_4 in_17_p sum1_4 332000.00
R1_18_4 in_18_n sum1_4 93100.00
R1_19_4 in_19_n sum1_4 11300.00
R1_20_4 in_20_n sum1_4 24300.00
R1_21_4 in_21_n sum1_4 9310.00
R1_22_4 in_22_p sum1_4 45300.00
R1_23_4 in_23_p sum1_4 845000.00
R1_24_4 in_24_n sum1_4 255000.00
R1_25_4 in_25_n sum1_4 84500.00
R1_26_4 in_26_n sum1_4 25500.00
R1_27_4 in_27_n sum1_4 13000.00
R1_28_4 in_28_n sum1_4 71500.00
R1_29_4 in_29_n sum1_4 19600.00
R1_30_4 in_30_p sum1_4 1020000.00
R1_33_4 in_33_p sum1_4 19600.00
R1_34_4 in_34_n sum1_4 38300.00
R1_35_4 in_35_n sum1_4 41200.00
R1_36_4 in_36_n sum1_4 243000.00
R1_37_4 in_37_n sum1_4 25500.00
R1_38_4 in_38_p sum1_4 41200.00
R1_41_4 in_41_p sum1_4 44200.00
R1_42_4 in_42_n sum1_4 43200.00
R1_43_4 in_43_p sum1_4 71500.00
R1_44_4 in_44_n sum1_4 34000.00
R1_45_4 in_45_p sum1_4 750000.00
R1_46_4 in_46_p sum1_4 22600.00
R1_47_4 in_47_p sum1_4 36500.00
R1_48_4 in_48_p sum1_4 243000.00
R1_49_4 in_49_n sum1_4 133000.00
R1_50_4 in_50_n sum1_4 53600.00
R1_51_4 in_51_p sum1_4 23200.00
R1_52_4 in_52_p sum1_4 22600.00
R1_53_4 in_53_p sum1_4 20000.00
R1_54_4 in_54_p sum1_4 29400.00
R1_55_4 in_55_n sum1_4 13000.00
R1_56_4 in_56_p sum1_4 1620000.00
R1_57_4 in_57_p sum1_4 22100.00
R1_58_4 in_58_p sum1_4 10700.00
R1_59_4 in_59_p sum1_4 29400.00
R1_60_4 in_60_n sum1_4 249000.00
R1_61_4 in_61_p sum1_4 40200.00
R1_62_4 in_62_p sum1_4 14300.00
R1_63_4 in_63_n sum1_4 137000.00
X_L1_5 0 sum1_5 v_sum1_5 vcc vee TL074
Rf_L1_5 sum1_5 v_sum1_5 10.0k
Cf_L1_5 sum1_5 v_sum1_5 5.0p
Rb_L1_5 ref_neg5 sum1_5 249000.00
R1_1_5 in_1_p sum1_5 113000.00
R1_2_5 in_2_n sum1_5 102000.00
R1_3_5 in_3_p sum1_5 39200.00
R1_4_5 in_4_p sum1_5 30100.00
R1_5_5 in_5_p sum1_5 52300.00
R1_6_5 in_6_n sum1_5 64900.00
R1_7_5 in_7_n sum1_5 97600.00
R1_9_5 in_9_p sum1_5 34000.00
R1_10_5 in_10_p sum1_5 140000.00
R1_11_5 in_11_p sum1_5 226000.00
R1_12_5 in_12_n sum1_5 30900.00
R1_13_5 in_13_n sum1_5 64900.00
R1_14_5 in_14_p sum1_5 33200.00
R1_15_5 in_15_n sum1_5 392000.00
R1_17_5 in_17_p sum1_5 88700.00
R1_18_5 in_18_n sum1_5 95300.00
R1_19_5 in_19_n sum1_5 45300.00
R1_20_5 in_20_n sum1_5 11300.00
R1_21_5 in_21_n sum1_5 20500.00
R1_22_5 in_22_n sum1_5 61900.00
R1_23_5 in_23_p sum1_5 243000.00
R1_25_5 in_25_n sum1_5 21000.00
R1_26_5 in_26_p sum1_5 48700.00
R1_27_5 in_27_p sum1_5 51100.00
R1_28_5 in_28_n sum1_5 28700.00
R1_29_5 in_29_n sum1_5 17400.00
R1_30_5 in_30_n sum1_5 10500.00
R1_33_5 in_33_p sum1_5 24300.00
R1_34_5 in_34_p sum1_5 41200.00
R1_35_5 in_35_p sum1_5 40200.00
R1_36_5 in_36_p sum1_5 21500.00
R1_37_5 in_37_n sum1_5 24300.00
R1_38_5 in_38_n sum1_5 12400.00
R1_41_5 in_41_n sum1_5 287000.00
R1_42_5 in_42_p sum1_5 12400.00
R1_43_5 in_43_p sum1_5 8250.00
R1_44_5 in_44_p sum1_5 16900.00
R1_45_5 in_45_n sum1_5 73200.00
R1_46_5 in_46_n sum1_5 19100.00
R1_47_5 in_47_n sum1_5 78700.00
R1_49_5 in_49_n sum1_5 237000.00
R1_50_5 in_50_n sum1_5 113000.00
R1_51_5 in_51_p sum1_5 14300.00
R1_52_5 in_52_p sum1_5 158000.00
R1_53_5 in_53_n sum1_5 22100.00
R1_54_5 in_54_n sum1_5 18700.00
R1_55_5 in_55_n sum1_5 35700.00
R1_57_5 in_57_p sum1_5 324000.00
R1_58_5 in_58_n sum1_5 178000.00
R1_59_5 in_59_p sum1_5 28700.00
R1_60_5 in_60_n sum1_5 57600.00
R1_61_5 in_61_n sum1_5 20500.00
R1_62_5 in_62_n sum1_5 22100.00
R1_63_5 in_63_n sum1_5 324000.00
X_L1_6 0 sum1_6 v_sum1_6 vcc vee TL074
Rf_L1_6 sum1_6 v_sum1_6 10.0k
Cf_L1_6 sum1_6 v_sum1_6 5.0p
Rb_L1_6 ref_neg5 sum1_6 133000.00
R1_1_6 in_1_p sum1_6 19100.00
R1_2_6 in_2_p sum1_6 17800.00
R1_3_6 in_3_p sum1_6 20500.00
R1_4_6 in_4_p sum1_6 169000.00
R1_5_6 in_5_p sum1_6 11500.00
R1_6_6 in_6_p sum1_6 12700.00
R1_7_6 in_7_n sum1_6 28000.00
R1_8_6 in_8_n sum1_6 5230000.00
R1_9_6 in_9_n sum1_6 16200.00
R1_10_6 in_10_n sum1_6 29400.00
R1_11_6 in_11_p sum1_6 34000.00
R1_12_6 in_12_p sum1_6 10200.00
R1_13_6 in_13_p sum1_6 73200.00
R1_14_6 in_14_n sum1_6 16900.00
R1_15_6 in_15_n sum1_6 25500.00
R1_16_6 in_16_p sum1_6 24900.00
R1_17_6 in_17_n sum1_6 42200.00
R1_18_6 in_18_n sum1_6 13300.00
R1_19_6 in_19_p sum1_6 18200.00
R1_20_6 in_20_p sum1_6 54900.00
R1_21_6 in_21_n sum1_6 11300.00
R1_22_6 in_22_n sum1_6 15800.00
R1_23_6 in_23_n sum1_6 237000.00
R1_24_6 in_24_p sum1_6 93100.00
R1_25_6 in_25_n sum1_6 178000.00
R1_26_6 in_26_n sum1_6 12700.00
R1_27_6 in_27_n sum1_6 16500.00
R1_28_6 in_28_n sum1_6 73200.00
R1_29_6 in_29_n sum1_6 39200.00
R1_30_6 in_30_n sum1_6 11300.00
R1_33_6 in_33_p sum1_6 26700.00
R1_34_6 in_34_n sum1_6 52300.00
R1_35_6 in_35_n sum1_6 23700.00
R1_36_6 in_36_n sum1_6 42200.00
R1_37_6 in_37_p sum1_6 392000.00
R1_38_6 in_38_p sum1_6 68100.00
R1_41_6 in_41_n sum1_6 9310.00
R1_42_6 in_42_n sum1_6 97600.00
R1_43_6 in_43_n sum1_6 24900.00
R1_44_6 in_44_n sum1_6 26100.00
R1_45_6 in_45_n sum1_6 165000.00
R1_46_6 in_46_n sum1_6 33200.00
R1_47_6 in_47_n sum1_6 3090000.00
R1_48_6 in_48_p sum1_6 1020000.00
R1_49_6 in_49_n sum1_6 14000.00
R1_50_6 in_50_n sum1_6 30100.00
R1_51_6 in_51_p sum1_6 21000.00
R1_52_6 in_52_p sum1_6 15400.00
R1_53_6 in_53_p sum1_6 78700.00
R1_54_6 in_54_n sum1_6 34800.00
R1_55_6 in_55_n sum1_6 174000.00
R1_56_6 in_56_p sum1_6 2740000.00
R1_57_6 in_57_p sum1_6 17400.00
R1_58_6 in_58_p sum1_6 18700.00
R1_59_6 in_59_p sum1_6 280000.00
R1_60_6 in_60_n sum1_6 71500.00
R1_61_6 in_61_p sum1_6 33200.00
R1_62_6 in_62_p sum1_6 16500.00
R1_63_6 in_63_p sum1_6 887000.00
X_L1_7 0 sum1_7 v_sum1_7 vcc vee TL074
Rf_L1_7 sum1_7 v_sum1_7 10.0k
Cf_L1_7 sum1_7 v_sum1_7 5.0p
Rb_L1_7 ref_neg5 sum1_7 158000.00
R1_1_7 in_1_p sum1_7 34000.00
R1_2_7 in_2_n sum1_7 61900.00
R1_3_7 in_3_n sum1_7 24900.00
R1_4_7 in_4_p sum1_7 46400.00
R1_5_7 in_5_p sum1_7 21000.00
R1_6_7 in_6_n sum1_7 32400.00
R1_7_7 in_7_n sum1_7 30900.00
R1_8_7 in_8_p sum1_7 3320000.00
R1_9_7 in_9_n sum1_7 26700.00
R1_10_7 in_10_n sum1_7 24300.00
R1_11_7 in_11_n sum1_7 26100.00
R1_12_7 in_12_n sum1_7 13700.00
R1_13_7 in_13_n sum1_7 73200.00
R1_14_7 in_14_n sum1_7 130000.00
R1_15_7 in_15_n sum1_7 60400.00
R1_16_7 in_16_p sum1_7 200000.00
R1_17_7 in_17_p sum1_7 18700.00
R1_18_7 in_18_p sum1_7 619000.00
R1_19_7 in_19_p sum1_7 23200.00
R1_20_7 in_20_n sum1_7 61900.00
R1_21_7 in_21_n sum1_7 12100.00
R1_22_7 in_22_n sum1_7 17800.00
R1_23_7 in_23_p sum1_7 2370000.00
R1_24_7 in_24_p sum1_7 422000.00
R1_25_7 in_25_p sum1_7 28000.00
R1_26_7 in_26_p sum1_7 18700.00
R1_27_7 in_27_p sum1_7 10500.00
R1_28_7 in_28_p sum1_7 12700.00
R1_29_7 in_29_n sum1_7 14700.00
R1_30_7 in_30_n sum1_7 8060.00
R1_33_7 in_33_p sum1_7 61900.00
R1_34_7 in_34_p sum1_7 16500.00
R1_35_7 in_35_p sum1_7 365000.00
R1_36_7 in_36_p sum1_7 21500.00
R1_37_7 in_37_n sum1_7 52300.00
R1_38_7 in_38_n sum1_7 22600.00
R1_41_7 in_41_n sum1_7 36500.00
R1_42_7 in_42_n sum1_7 23200.00
R1_43_7 in_43_n sum1_7 9760.00
R1_44_7 in_44_p sum1_7 18700.00
R1_45_7 in_45_p sum1_7 38300.00
R1_46_7 in_46_p sum1_7 46400.00
R1_47_7 in_47_p sum1_7 619000.00
R1_48_7 in_48_n sum1_7 750000.00
R1_49_7 in_49_n sum1_7 21000.00
R1_50_7 in_50_n sum1_7 26100.00
R1_51_7 in_51_n sum1_7 19600.00
R1_52_7 in_52_p sum1_7 30900.00
R1_53_7 in_53_n sum1_7 36500.00
R1_54_7 in_54_n sum1_7 143000.00
R1_55_7 in_55_n sum1_7 255000.00
R1_56_7 in_56_n sum1_7 2430000.00
R1_57_7 in_57_p sum1_7 45300.00
R1_58_7 in_58_n sum1_7 90900.00
R1_59_7 in_59_n sum1_7 80600.00
R1_60_7 in_60_p sum1_7 23700.00
R1_61_7 in_61_n sum1_7 1000000.00
R1_62_7 in_62_n sum1_7 12700.00
R1_63_7 in_63_n sum1_7 22600.00
X_L1_8 0 sum1_8 v_sum1_8 vcc vee TL074
Rf_L1_8 sum1_8 v_sum1_8 10.0k
Cf_L1_8 sum1_8 v_sum1_8 5.0p
Rb_L1_8 ref_pos5 sum1_8 4870000.00
R1_1_8 in_1_n sum1_8 357000.00
R1_2_8 in_2_p sum1_8 54900.00
R1_3_8 in_3_n sum1_8 47500.00
R1_4_8 in_4_n sum1_8 19100.00
R1_5_8 in_5_n sum1_8 23200.00
R1_6_8 in_6_p sum1_8 25500.00
R1_7_8 in_7_n sum1_8 124000.00
R1_8_8 in_8_p sum1_8 9760000.00
R1_9_8 in_9_n sum1_8 348000.00
R1_10_8 in_10_n sum1_8 34000.00
R1_11_8 in_11_p sum1_8 97600.00
R1_12_8 in_12_n sum1_8 32400.00
R1_13_8 in_13_n sum1_8 20500.00
R1_14_8 in_14_n sum1_8 182000.00
R1_15_8 in_15_n sum1_8 178000.00
R1_16_8 in_16_p sum1_8 9760000.00
R1_17_8 in_17_p sum1_8 38300.00
R1_18_8 in_18_p sum1_8 11000.00
R1_19_8 in_19_p sum1_8 13000.00
R1_20_8 in_20_n sum1_8 11500.00
R1_21_8 in_21_n sum1_8 24300.00
R1_22_8 in_22_n sum1_8 10700.00
R1_23_8 in_23_n sum1_8 9760000.00
R1_25_8 in_25_p sum1_8 23200.00
R1_26_8 in_26_p sum1_8 11300.00
R1_27_8 in_27_p sum1_8 46400.00
R1_28_8 in_28_n sum1_8 49900.00
R1_29_8 in_29_p sum1_8 60400.00
R1_30_8 in_30_p sum1_8 14700.00
R1_33_8 in_33_p sum1_8 15000.00
R1_34_8 in_34_p sum1_8 11800.00
R1_35_8 in_35_n sum1_8 39200.00
R1_36_8 in_36_n sum1_8 20500.00
R1_37_8 in_37_p sum1_8 15800.00
R1_38_8 in_38_p sum1_8 11800.00
R1_41_8 in_41_n sum1_8 187000.00
R1_42_8 in_42_p sum1_8 36500.00
R1_43_8 in_43_p sum1_8 32400.00
R1_44_8 in_44_p sum1_8 162000.00
R1_45_8 in_45_n sum1_8 80600.00
R1_46_8 in_46_n sum1_8 61900.00
R1_47_8 in_47_p sum1_8 649000.00
R1_48_8 in_48_n sum1_8 1370000.00
R1_49_8 in_49_p sum1_8 1050000.00
R1_50_8 in_50_n sum1_8 732000.00
R1_51_8 in_51_p sum1_8 38300.00
R1_52_8 in_52_n sum1_8 18700.00
R1_53_8 in_53_n sum1_8 17400.00
R1_54_8 in_54_n sum1_8 12400.00
R1_55_8 in_55_n sum1_8 75000.00
R1_56_8 in_56_n sum1_8 3920000.00
R1_57_8 in_57_n sum1_8 25500.00
R1_58_8 in_58_p sum1_8 365000.00
R1_59_8 in_59_n sum1_8 16200.00
R1_60_8 in_60_n sum1_8 30900.00
R1_61_8 in_61_n sum1_8 34800.00
R1_62_8 in_62_n sum1_8 80600.00
R1_63_8 in_63_n sum1_8 28700.00
X_L1_9 0 sum1_9 v_sum1_9 vcc vee TL074
Rf_L1_9 sum1_9 v_sum1_9 10.0k
Cf_L1_9 sum1_9 v_sum1_9 5.0p
Rb_L1_9 ref_pos5 sum1_9 442000.00
R1_2_9 in_2_p sum1_9 133000.00
R1_3_9 in_3_p sum1_9 34800.00
R1_4_9 in_4_p sum1_9 261000.00
R1_5_9 in_5_p sum1_9 442000.00
R1_6_9 in_6_n sum1_9 9760000.00
R1_9_9 in_9_p sum1_9 976000.00
R1_10_9 in_10_p sum1_9 43200.00
R1_11_9 in_11_p sum1_9 57600.00
R1_12_9 in_12_n sum1_9 97600.00
R1_13_9 in_13_n sum1_9 2050000.00
R1_17_9 in_17_p sum1_9 332000.00
R1_18_9 in_18_n sum1_9 634000.00
R1_19_9 in_19_p sum1_9 365000.00
R1_20_9 in_20_n sum1_9 130000.00
R1_21_9 in_21_p sum1_9 909000.00
R1_22_9 in_22_p sum1_9 2940000.00
R1_25_9 in_25_p sum1_9 294000.00
R1_26_9 in_26_p sum1_9 102000.00
R1_27_9 in_27_p sum1_9 73200.00
R1_28_9 in_28_p sum1_9 294000.00
R1_29_9 in_29_p sum1_9 113000.00
R1_30_9 in_30_n sum1_9 1270000.00
R1_33_9 in_33_p sum1_9 768000.00
R1_34_9 in_34_p sum1_9 221000.00
R1_35_9 in_35_n sum1_9 75000.00
R1_36_9 in_36_n sum1_9 100000.00
R1_37_9 in_37_p sum1_9 49900.00
R1_38_9 in_38_p sum1_9 9760000.00
R1_41_9 in_41_n sum1_9 887000.00
R1_42_9 in_42_p sum1_9 48700.00
R1_43_9 in_43_p sum1_9 255000.00
R1_44_9 in_44_n sum1_9 221000.00
R1_45_9 in_45_n sum1_9 64900.00
R1_46_9 in_46_p sum1_9 590000.00
R1_49_9 in_49_n sum1_9 1540000.00
R1_50_9 in_50_p sum1_9 665000.00
R1_51_9 in_51_n sum1_9 118000.00
R1_52_9 in_52_p sum1_9 324000.00
R1_53_9 in_53_p sum1_9 113000.00
R1_54_9 in_54_p sum1_9 287000.00
R1_58_9 in_58_p sum1_9 174000.00
R1_59_9 in_59_n sum1_9 169000.00
R1_60_9 in_60_p sum1_9 121000.00
R1_61_9 in_61_p sum1_9 549000.00
R1_62_9 in_62_p sum1_9 1540000.00
X_L1_10 0 sum1_10 v_sum1_10 vcc vee TL074
Rf_L1_10 sum1_10 v_sum1_10 10.0k
Cf_L1_10 sum1_10 v_sum1_10 5.0p
Rb_L1_10 ref_pos5 sum1_10 402000.00
R1_2_10 in_2_p sum1_10 3010000.00
R1_3_10 in_3_n sum1_10 162000.00
R1_4_10 in_4_p sum1_10 93100.00
R1_5_10 in_5_p sum1_10 1070000.00
R1_6_10 in_6_p sum1_10 3240000.00
R1_9_10 in_9_p sum1_10 9760000.00
R1_10_10 in_10_p sum1_10 9760000.00
R1_11_10 in_11_p sum1_10 73200.00
R1_12_10 in_12_p sum1_10 294000.00
R1_13_10 in_13_p sum1_10 475000.00
R1_14_10 in_14_p sum1_10 1020000.00
R1_18_10 in_18_p sum1_10 107000.00
R1_19_10 in_19_p sum1_10 102000.00
R1_20_10 in_20_n sum1_10 9760000.00
R1_21_10 in_21_n sum1_10 226000.00
R1_22_10 in_22_p sum1_10 2870000.00
R1_25_10 in_25_p sum1_10 1180000.00
R1_26_10 in_26_n sum1_10 549000.00
R1_27_10 in_27_p sum1_10 221000.00
R1_28_10 in_28_p sum1_10 4320000.00
R1_29_10 in_29_p sum1_10 100000.00
R1_30_10 in_30_p sum1_10 845000.00
R1_33_10 in_33_p sum1_10 1400000.00
R1_34_10 in_34_p sum1_10 309000.00
R1_35_10 in_35_n sum1_10 422000.00
R1_36_10 in_36_p sum1_10 249000.00
R1_37_10 in_37_p sum1_10 68100.00
R1_38_10 in_38_n sum1_10 1430000.00
R1_41_10 in_41_n sum1_10 825000.00
R1_42_10 in_42_p sum1_10 549000.00
R1_43_10 in_43_n sum1_10 174000.00
R1_44_10 in_44_n sum1_10 143000.00
R1_45_10 in_45_p sum1_10 953000.00
R1_50_10 in_50_p sum1_10 3090000.00
R1_51_10 in_51_p sum1_10 66500.00
R1_52_10 in_52_p sum1_10 280000.00
R1_54_10 in_54_n sum1_10 3570000.00
R1_58_10 in_58_p sum1_10 887000.00
R1_59_10 in_59_p sum1_10 267000.00
R1_60_10 in_60_p sum1_10 487000.00
R1_61_10 in_61_n sum1_10 9760000.00
R1_62_10 in_62_n sum1_10 2670000.00
X_L1_11 0 sum1_11 v_sum1_11 vcc vee TL074
Rf_L1_11 sum1_11 v_sum1_11 10.0k
Cf_L1_11 sum1_11 v_sum1_11 5.0p
Rb_L1_11 ref_neg5 sum1_11 84500.00
R1_1_11 in_1_n sum1_11 30900.00
R1_2_11 in_2_n sum1_11 36500.00
R1_3_11 in_3_n sum1_11 33200.00
R1_4_11 in_4_n sum1_11 10700.00
R1_5_11 in_5_n sum1_11 24300.00
R1_6_11 in_6_n sum1_11 23200.00
R1_7_11 in_7_p sum1_11 69800.00
R1_8_11 in_8_n sum1_11 9760000.00
R1_9_11 in_9_n sum1_11 19600.00
R1_10_11 in_10_n sum1_11 17400.00
R1_11_11 in_11_n sum1_11 17800.00
R1_12_11 in_12_p sum1_11 44200.00
R1_13_11 in_13_n sum1_11 23700.00
R1_14_11 in_14_n sum1_11 43200.00
R1_15_11 in_15_p sum1_11 105000.00
R1_16_11 in_16_p sum1_11 26100.00
R1_17_11 in_17_p sum1_11 42200.00
R1_18_11 in_18_p sum1_11 90900.00
R1_19_11 in_19_p sum1_11 34000.00
R1_20_11 in_20_p sum1_11 11800.00
R1_21_11 in_21_p sum1_11 42200.00
R1_22_11 in_22_p sum1_11 3740000.00
R1_23_11 in_23_p sum1_11 57600.00
R1_24_11 in_24_p sum1_11 69800.00
R1_25_11 in_25_p sum1_11 88700.00
R1_26_11 in_26_p sum1_11 34800.00
R1_27_11 in_27_n sum1_11 63400.00
R1_28_11 in_28_n sum1_11 34000.00
R1_29_11 in_29_p sum1_11 73200.00
R1_30_11 in_30_p sum1_11 14300.00
R1_33_11 in_33_n sum1_11 215000.00
R1_34_11 in_34_n sum1_11 56200.00
R1_35_11 in_35_n sum1_11 38300.00
R1_36_11 in_36_p sum1_11 28000.00
R1_37_11 in_37_p sum1_11 107000.00
R1_38_11 in_38_n sum1_11 47500.00
R1_41_11 in_41_p sum1_11 12400.00
R1_42_11 in_42_n sum1_11 97600.00
R1_43_11 in_43_p sum1_11 8660.00
R1_44_11 in_44_p sum1_11 30900.00
R1_45_11 in_45_n sum1_11 10700.00
R1_46_11 in_46_n sum1_11 12400.00
R1_47_11 in_47_p sum1_11 3320000.00
R1_49_11 in_49_p sum1_11 16900.00
R1_50_11 in_50_n sum1_11 24300.00
R1_51_11 in_51_p sum1_11 24900.00
R1_52_11 in_52_p sum1_11 24300.00
R1_53_11 in_53_n sum1_11 21500.00
R1_54_11 in_54_n sum1_11 30100.00
R1_55_11 in_55_p sum1_11 11800.00
R1_57_11 in_57_n sum1_11 73200.00
R1_58_11 in_58_n sum1_11 17400.00
R1_59_11 in_59_n sum1_11 15000.00
R1_60_11 in_60_n sum1_11 78700.00
R1_61_11 in_61_p sum1_11 30100.00
R1_62_11 in_62_p sum1_11 21500.00
R1_63_11 in_63_p sum1_11 11800.00
X_L1_12 0 sum1_12 v_sum1_12 vcc vee TL074
Rf_L1_12 sum1_12 v_sum1_12 10.0k
Cf_L1_12 sum1_12 v_sum1_12 5.0p
Rb_L1_12 ref_pos5 sum1_12 549000.00
R1_2_12 in_2_p sum1_12 1780000.00
R1_3_12 in_3_p sum1_12 200000.00
R1_4_12 in_4_p sum1_12 1540000.00
R1_5_12 in_5_n sum1_12 9760000.00
R1_9_12 in_9_n sum1_12 9760000.00
R1_10_12 in_10_p sum1_12 1210000.00
R1_11_12 in_11_p sum1_12 162000.00
R1_12_12 in_12_p sum1_12 169000.00
R1_13_12 in_13_p sum1_12 2740000.00
R1_17_12 in_17_p sum1_12 8250000.00
R1_18_12 in_18_n sum1_12 365000.00
R1_19_12 in_19_p sum1_12 562000.00
R1_20_12 in_20_n sum1_12 4020000.00
R1_21_12 in_21_p sum1_12 169000.00
R1_22_12 in_22_p sum1_12 9760000.00
R1_25_12 in_25_p sum1_12 9760000.00
R1_26_12 in_26_p sum1_12 309000.00
R1_27_12 in_27_p sum1_12 909000.00
R1_28_12 in_28_p sum1_12 8060000.00
R1_29_12 in_29_n sum1_12 5900000.00
R1_30_12 in_30_n sum1_12 3570000.00
R1_33_12 in_33_n sum1_12 4530000.00
R1_34_12 in_34_n sum1_12 243000.00
R1_35_12 in_35_p sum1_12 432000.00
R1_36_12 in_36_p sum1_12 453000.00
R1_37_12 in_37_p sum1_12 1020000.00
R1_38_12 in_38_p sum1_12 9760000.00
R1_41_12 in_41_n sum1_12 9760000.00
R1_42_12 in_42_n sum1_12 249000.00
R1_43_12 in_43_p sum1_12 2000000.00
R1_44_12 in_44_p sum1_12 866000.00
R1_45_12 in_45_p sum1_12 698000.00
R1_50_12 in_50_n sum1_12 191000.00
R1_51_12 in_51_p sum1_12 1470000.00
R1_52_12 in_52_p sum1_12 412000.00
R1_53_12 in_53_n sum1_12 261000.00
R1_54_12 in_54_p sum1_12 9760000.00
R1_58_12 in_58_n sum1_12 9760000.00
R1_59_12 in_59_p sum1_12 154000.00
R1_60_12 in_60_n sum1_12 768000.00
R1_61_12 in_61_p sum1_12 665000.00
R1_62_12 in_62_p sum1_12 9760000.00
X_L1_13 0 sum1_13 v_sum1_13 vcc vee TL074
Rf_L1_13 sum1_13 v_sum1_13 10.0k
Cf_L1_13 sum1_13 v_sum1_13 5.0p
Rb_L1_13 ref_pos5 sum1_13 169000.00
R1_1_13 in_1_n sum1_13 118000.00
R1_2_13 in_2_p sum1_13 21500.00
R1_3_13 in_3_n sum1_13 196000.00
R1_4_13 in_4_n sum1_13 76800.00
R1_5_13 in_5_p sum1_13 178000.00
R1_6_13 in_6_n sum1_13 24900.00
R1_7_13 in_7_n sum1_13 37400.00
R1_9_13 in_9_p sum1_13 107000.00
R1_10_13 in_10_p sum1_13 19100.00
R1_11_13 in_11_p sum1_13 28700.00
R1_12_13 in_12_n sum1_13 26700.00
R1_13_13 in_13_p sum1_13 147000.00
R1_14_13 in_14_p sum1_13 49900.00
R1_15_13 in_15_p sum1_13 576000.00
R1_17_13 in_17_p sum1_13 14300.00
R1_18_13 in_18_p sum1_13 9530.00
R1_19_13 in_19_p sum1_13 13300.00
R1_20_13 in_20_n sum1_13 14300.00
R1_21_13 in_21_p sum1_13 46400.00
R1_22_13 in_22_n sum1_13 115000.00
R1_23_13 in_23_n sum1_13 2100000.00
R1_25_13 in_25_p sum1_13 75000.00
R1_26_13 in_26_n sum1_13 261000.00
R1_27_13 in_27_p sum1_13 34000.00
R1_28_13 in_28_n sum1_13 24900.00
R1_29_13 in_29_n sum1_13 23700.00
R1_30_13 in_30_n sum1_13 9760.00
R1_33_13 in_33_n sum1_13 28700.00
R1_34_13 in_34_n sum1_13 26100.00
R1_35_13 in_35_n sum1_13 113000.00
R1_36_13 in_36_n sum1_13 12700.00
R1_37_13 in_37_n sum1_13 9310.00
R1_38_13 in_38_n sum1_13 8060.00
R1_41_13 in_41_n sum1_13 61900.00
R1_42_13 in_42_p sum1_13 16500.00
R1_43_13 in_43_n sum1_13 34800.00
R1_44_13 in_44_n sum1_13 35700.00
R1_45_13 in_45_p sum1_13 34800.00
R1_46_13 in_46_p sum1_13 165000.00
R1_49_13 in_49_n sum1_13 118000.00
R1_50_13 in_50_p sum1_13 11500.00
R1_51_13 in_51_n sum1_13 105000.00
R1_52_13 in_52_p sum1_13 49900.00
R1_53_13 in_53_p sum1_13 9090.00
R1_54_13 in_54_p sum1_13 11500.00
R1_55_13 in_55_p sum1_13 1740000.00
R1_57_13 in_57_n sum1_13 768000.00
R1_58_13 in_58_n sum1_13 23700.00
R1_59_13 in_59_p sum1_13 17800.00
R1_60_13 in_60_p sum1_13 14000.00
R1_61_13 in_61_p sum1_13 18700.00
R1_62_13 in_62_p sum1_13 33200.00
R1_63_13 in_63_p sum1_13 261000.00
X_L1_14 0 sum1_14 v_sum1_14 vcc vee TL074
Rf_L1_14 sum1_14 v_sum1_14 10.0k
Cf_L1_14 sum1_14 v_sum1_14 5.0p
Rb_L1_14 ref_neg5 sum1_14 2370000.00
R1_1_14 in_1_p sum1_14 37400.00
R1_2_14 in_2_p sum1_14 215000.00
R1_3_14 in_3_n sum1_14 511000.00
R1_4_14 in_4_p sum1_14 26700.00
R1_5_14 in_5_n sum1_14 154000.00
R1_6_14 in_6_p sum1_14 18700.00
R1_7_14 in_7_p sum1_14 226000.00
R1_8_14 in_8_n sum1_14 9760000.00
R1_9_14 in_9_p sum1_14 19600.00
R1_10_14 in_10_p sum1_14 210000.00
R1_11_14 in_11_p sum1_14 53600.00
R1_12_14 in_12_p sum1_14 12100.00
R1_13_14 in_13_n sum1_14 124000.00
R1_14_14 in_14_n sum1_14 121000.00
R1_15_14 in_15_p sum1_14 825000.00
R1_16_14 in_16_p sum1_14 1430000.00
R1_17_14 in_17_p sum1_14 33200.00
R1_18_14 in_18_p sum1_14 165000.00
R1_19_14 in_19_n sum1_14 31600.00
R1_20_14 in_20_n sum1_14 93100.00
R1_21_14 in_21_p sum1_14 36500.00
R1_22_14 in_22_n sum1_14 38300.00
R1_24_14 in_24_p sum1_14 698000.00
R1_25_14 in_25_p sum1_14 84500.00
R1_26_14 in_26_p sum1_14 25500.00
R1_27_14 in_27_n sum1_14 27400.00
R1_28_14 in_28_p sum1_14 31600.00
R1_29_14 in_29_p sum1_14 26100.00
R1_30_14 in_30_p sum1_14 10500.00
R1_33_14 in_33_n sum1_14 48700.00
R1_34_14 in_34_n sum1_14 100000.00
R1_35_14 in_35_n sum1_14 20000.00
R1_36_14 in_36_n sum1_14 69800.00
R1_37_14 in_37_p sum1_14 732000.00
R1_38_14 in_38_p sum1_14 12400.00
R1_41_14 in_41_n sum1_14 54900.00
R1_42_14 in_42_n sum1_14 6980.00
R1_43_14 in_43_n sum1_14 10000.00
R1_44_14 in_44_n sum1_14 32400.00
R1_45_14 in_45_p sum1_14 8660000.00
R1_46_14 in_46_n sum1_14 47500.00
R1_47_14 in_47_n sum1_14 113000.00
R1_48_14 in_48_n sum1_14 1870000.00
R1_49_14 in_49_p sum1_14 15400.00
R1_50_14 in_50_n sum1_14 11000.00
R1_51_14 in_51_n sum1_14 75000.00
R1_52_14 in_52_p sum1_14 59000.00
R1_53_14 in_53_n sum1_14 13000.00
R1_54_14 in_54_n sum1_14 18200.00
R1_55_14 in_55_p sum1_14 1400000.00
R1_56_14 in_56_n sum1_14 4990000.00
R1_57_14 in_57_p sum1_14 453000.00
R1_58_14 in_58_p sum1_14 14300.00
R1_59_14 in_59_n sum1_14 51100.00
R1_60_14 in_60_n sum1_14 24300.00
R1_61_14 in_61_n sum1_14 13700.00
R1_62_14 in_62_p sum1_14 84500.00
R1_63_14 in_63_n sum1_14 66500.00
X_L1_15 0 sum1_15 v_sum1_15 vcc vee TL074
Rf_L1_15 sum1_15 v_sum1_15 10.0k
Cf_L1_15 sum1_15 v_sum1_15 5.0p
Rb_L1_15 ref_pos5 sum1_15 619000.00

* =====================================================================
* LAYER 1 ACTIVATION: 16 PRECISION ACTIVE RECTIFIERS (DC2 ReLU)
* =====================================================================
X_RELU_0 v_sum1_0 v_act_0 oa_relu_0 vcc vee TL074
D_FWD_0 oa_relu_0 v_act_0 1N4148
D_CLP_0 0 oa_relu_0 1N4148
R_PD_0 v_act_0 0 20k
X_RELU_1 v_sum1_1 v_act_1 oa_relu_1 vcc vee TL074
D_FWD_1 oa_relu_1 v_act_1 1N4148
D_CLP_1 0 oa_relu_1 1N4148
R_PD_1 v_act_1 0 20k
X_RELU_2 v_sum1_2 v_act_2 oa_relu_2 vcc vee TL074
D_FWD_2 oa_relu_2 v_act_2 1N4148
D_CLP_2 0 oa_relu_2 1N4148
R_PD_2 v_act_2 0 20k
X_RELU_3 v_sum1_3 v_act_3 oa_relu_3 vcc vee TL074
D_FWD_3 oa_relu_3 v_act_3 1N4148
D_CLP_3 0 oa_relu_3 1N4148
R_PD_3 v_act_3 0 20k
X_RELU_4 v_sum1_4 v_act_4 oa_relu_4 vcc vee TL074
D_FWD_4 oa_relu_4 v_act_4 1N4148
D_CLP_4 0 oa_relu_4 1N4148
R_PD_4 v_act_4 0 20k
X_RELU_5 v_sum1_5 v_act_5 oa_relu_5 vcc vee TL074
D_FWD_5 oa_relu_5 v_act_5 1N4148
D_CLP_5 0 oa_relu_5 1N4148
R_PD_5 v_act_5 0 20k
X_RELU_6 v_sum1_6 v_act_6 oa_relu_6 vcc vee TL074
D_FWD_6 oa_relu_6 v_act_6 1N4148
D_CLP_6 0 oa_relu_6 1N4148
R_PD_6 v_act_6 0 20k
X_RELU_7 v_sum1_7 v_act_7 oa_relu_7 vcc vee TL074
D_FWD_7 oa_relu_7 v_act_7 1N4148
D_CLP_7 0 oa_relu_7 1N4148
R_PD_7 v_act_7 0 20k
X_RELU_8 v_sum1_8 v_act_8 oa_relu_8 vcc vee TL074
D_FWD_8 oa_relu_8 v_act_8 1N4148
D_CLP_8 0 oa_relu_8 1N4148
R_PD_8 v_act_8 0 20k
X_RELU_9 v_sum1_9 v_act_9 oa_relu_9 vcc vee TL074
D_FWD_9 oa_relu_9 v_act_9 1N4148
D_CLP_9 0 oa_relu_9 1N4148
R_PD_9 v_act_9 0 20k
X_RELU_10 v_sum1_10 v_act_10 oa_relu_10 vcc vee TL074
D_FWD_10 oa_relu_10 v_act_10 1N4148
D_CLP_10 0 oa_relu_10 1N4148
R_PD_10 v_act_10 0 20k
X_RELU_11 v_sum1_11 v_act_11 oa_relu_11 vcc vee TL074
D_FWD_11 oa_relu_11 v_act_11 1N4148
D_CLP_11 0 oa_relu_11 1N4148
R_PD_11 v_act_11 0 20k
X_RELU_12 v_sum1_12 v_act_12 oa_relu_12 vcc vee TL074
D_FWD_12 oa_relu_12 v_act_12 1N4148
D_CLP_12 0 oa_relu_12 1N4148
R_PD_12 v_act_12 0 20k
X_RELU_13 v_sum1_13 v_act_13 oa_relu_13 vcc vee TL074
D_FWD_13 oa_relu_13 v_act_13 1N4148
D_CLP_13 0 oa_relu_13 1N4148
R_PD_13 v_act_13 0 20k
X_RELU_14 v_sum1_14 v_act_14 oa_relu_14 vcc vee TL074
D_FWD_14 oa_relu_14 v_act_14 1N4148
D_CLP_14 0 oa_relu_14 1N4148
R_PD_14 v_act_14 0 20k
X_RELU_15 v_sum1_15 v_act_15 oa_relu_15 vcc vee TL074
D_FWD_15 oa_relu_15 v_act_15 1N4148
D_CLP_15 0 oa_relu_15 1N4148
R_PD_15 v_act_15 0 20k

* =====================================================================
* LAYER 2: 10 DIGIT CLASS SUMMING AMPLIFIERS (DC3)
* =====================================================================
X_L2_0 0 sum2_0 v_class_0 vcc vee TL074
Rf_L2_0 sum2_0 v_class_0 10.0k
Cf_L2_0 sum2_0 v_class_0 5.0p
Rb_L2_0 ref_neg5 sum2_0 442000.00
R2_0_0 v_act_0 sum2_0 12400.00
R2_1_0 v_act_n_1 sum2_0 10000.00
R2_2_0 v_act_2 sum2_0 143000.00
R2_4_0 v_act_n_4 sum2_0 33200.00
R2_5_0 v_act_5 sum2_0 46400.00
R2_6_0 v_act_6 sum2_0 162000.00
R2_7_0 v_act_n_7 sum2_0 11300.00
R2_8_0 v_act_8 sum2_0 7680.00
R2_9_0 v_act_9 sum2_0 88700.00
R2_11_0 v_act_n_11 sum2_0 71500.00
R2_12_0 v_act_n_12 sum2_0 196000.00
R2_13_0 v_act_13 sum2_0 12400.00
R2_14_0 v_act_14 sum2_0 51100.00
X_L2_1 0 sum2_1 v_class_1 vcc vee TL074
Rf_L2_1 sum2_1 v_class_1 10.0k
Cf_L2_1 sum2_1 v_class_1 5.0p
Rb_L2_1 ref_pos5 sum2_1 226000.00
R2_0_1 v_act_n_0 sum2_1 15000.00
R2_1_1 v_act_1 sum2_1 59000.00
R2_2_1 v_act_n_2 sum2_1 30100.00
R2_4_1 v_act_n_4 sum2_1 13300.00
R2_5_1 v_act_n_5 sum2_1 10200.00
R2_6_1 v_act_6 sum2_1 15800.00
R2_7_1 v_act_7 sum2_1 20500.00
R2_8_1 v_act_n_8 sum2_1 115000.00
R2_9_1 v_act_n_9 sum2_1 133000.00
R2_10_1 v_act_n_10 sum2_1 511000.00
R2_11_1 v_act_11 sum2_1 8060.00
R2_13_1 v_act_13 sum2_1 32400.00
R2_14_1 v_act_n_14 sum2_1 21000.00
X_L2_2 0 sum2_2 v_class_2 vcc vee TL074
Rf_L2_2 sum2_2 v_class_2 10.0k
Cf_L2_2 sum2_2 v_class_2 5.0p
Rb_L2_2 ref_neg5 sum2_2 665000.00
R2_0_2 v_act_0 sum2_2 10200.00
R2_1_2 v_act_1 sum2_2 9530.00
R2_2_2 v_act_n_2 sum2_2 45300.00
R2_4_2 v_act_4 sum2_2 8060.00
R2_5_2 v_act_5 sum2_2 13700.00
R2_6_2 v_act_6 sum2_2 17800.00
R2_7_2 v_act_n_7 sum2_2 7500.00
R2_8_2 v_act_n_8 sum2_2 17800.00
R2_9_2 v_act_n_9 sum2_2 9760000.00
R2_11_2 v_act_11 sum2_2 38300.00
R2_13_2 v_act_13 sum2_2 19600.00
R2_14_2 v_act_n_14 sum2_2 17400.00
X_L2_3 0 sum2_3 v_class_3 vcc vee TL074
Rf_L2_3 sum2_3 v_class_3 10.0k
Cf_L2_3 sum2_3 v_class_3 5.0p
Rb_L2_3 ref_pos5 sum2_3 243000.00
R2_0_3 v_act_0 sum2_3 23700.00
R2_1_3 v_act_n_1 sum2_3 23700.00
R2_2_3 v_act_2 sum2_3 14300.00
R2_4_3 v_act_4 sum2_3 14000.00
R2_5_3 v_act_n_5 sum2_3 68100.00
R2_6_3 v_act_6 sum2_3 14700.00
R2_7_3 v_act_7 sum2_3 18200.00
R2_8_3 v_act_n_8 sum2_3 11000.00
R2_9_3 v_act_9 sum2_3 215000.00
R2_10_3 v_act_n_10 sum2_3 4990000.00
R2_11_3 v_act_n_11 sum2_3 19600.00
R2_12_3 v_act_n_12 sum2_3 5620000.00
R2_13_3 v_act_13 sum2_3 28700.00
R2_14_3 v_act_14 sum2_3 49900.00
X_L2_4 0 sum2_4 v_class_4 vcc vee TL074
Rf_L2_4 sum2_4 v_class_4 10.0k
Cf_L2_4 sum2_4 v_class_4 5.0p
Rb_L2_4 ref_neg5 sum2_4 243000.00
R2_0_4 v_act_n_0 sum2_4 14000.00
R2_1_4 v_act_n_1 sum2_4 8450.00
R2_2_4 v_act_2 sum2_4 16500.00
R2_4_4 v_act_n_4 sum2_4 604000.00
R2_5_4 v_act_5 sum2_4 19100.00
R2_6_4 v_act_n_6 sum2_4 8870.00
R2_7_4 v_act_n_7 sum2_4 86600.00
R2_8_4 v_act_8 sum2_4 14300.00
R2_9_4 v_act_n_9 sum2_4 750000.00
R2_10_4 v_act_10 sum2_4 511000.00
R2_11_4 v_act_11 sum2_4 5760.00
R2_12_4 v_act_n_12 sum2_4 1050000.00
R2_13_4 v_act_n_13 sum2_4 16200.00
R2_14_4 v_act_14 sum2_4 42200.00
X_L2_5 0 sum2_5 v_class_5 vcc vee TL074
Rf_L2_5 sum2_5 v_class_5 10.0k
Cf_L2_5 sum2_5 v_class_5 5.0p
Rb_L2_5 ref_neg5 sum2_5 383000.00
R2_0_5 v_act_n_0 sum2_5 11300.00
R2_1_5 v_act_1 sum2_5 97600.00
R2_2_5 v_act_n_2 sum2_5 107000.00
R2_4_5 v_act_4 sum2_5 27400.00
R2_5_5 v_act_n_5 sum2_5 39200.00
R2_6_5 v_act_6 sum2_5 34000.00
R2_7_5 v_act_7 sum2_5 12100.00
R2_8_5 v_act_8 sum2_5 13000.00
R2_9_5 v_act_n_9 sum2_5 56200.00
R2_11_5 v_act_n_11 sum2_5 10200.00
R2_12_5 v_act_n_12 sum2_5 866000.00
R2_13_5 v_act_13 sum2_5 14000.00
R2_14_5 v_act_14 sum2_5 9310.00
X_L2_6 0 sum2_6 v_class_6 vcc vee TL074
Rf_L2_6 sum2_6 v_class_6 10.0k
Cf_L2_6 sum2_6 v_class_6 5.0p
Rb_L2_6 ref_pos5 sum2_6 80600.00
R2_0_6 v_act_n_0 sum2_6 301000.00
R2_1_6 v_act_n_1 sum2_6 14000.00
R2_2_6 v_act_2 sum2_6 22100.00
R2_4_6 v_act_4 sum2_6 16200.00
R2_5_6 v_act_n_5 sum2_6 732000.00
R2_6_6 v_act_n_6 sum2_6 33200.00
R2_7_6 v_act_7 sum2_6 38300.00
R2_8_6 v_act_8 sum2_6 9760.00
R2_9_6 v_act_9 sum2_6 348000.00
R2_11_6 v_act_11 sum2_6 48700.00
R2_12_6 v_act_n_12 sum2_6 2050000.00
R2_13_6 v_act_13 sum2_6 14700.00
R2_14_6 v_act_n_14 sum2_6 10200.00
X_L2_7 0 sum2_7 v_class_7 vcc vee TL074
Rf_L2_7 sum2_7 v_class_7 10.0k
Cf_L2_7 sum2_7 v_class_7 5.0p
Rb_L2_7 ref_neg5 sum2_7 2370000.00
R2_0_7 v_act_n_0 sum2_7 19600.00
R2_1_7 v_act_1 sum2_7 30900.00
R2_2_7 v_act_2 sum2_7 9760.00
R2_4_7 v_act_4 sum2_7 604000.00
R2_5_7 v_act_5 sum2_7 8250.00
R2_6_7 v_act_6 sum2_7 33200.00
R2_7_7 v_act_n_7 sum2_7 9090.00
R2_8_7 v_act_8 sum2_7 73200.00
R2_9_7 v_act_9 sum2_7 9760000.00
R2_10_7 v_act_n_10 sum2_7 1100000.00
R2_11_7 v_act_n_11 sum2_7 73200.00
R2_12_7 v_act_n_12 sum2_7 9760000.00
R2_13_7 v_act_n_13 sum2_7 7870.00
R2_14_7 v_act_14 sum2_7 28700.00
X_L2_8 0 sum2_8 v_class_8 vcc vee TL074
Rf_L2_8 sum2_8 v_class_8 10.0k
Cf_L2_8 sum2_8 v_class_8 5.0p
Rb_L2_8 ref_neg5 sum2_8 191000.00
R2_0_8 v_act_0 sum2_8 22600.00
R2_1_8 v_act_1 sum2_8 16900.00
R2_2_8 v_act_2 sum2_8 100000.00
R2_4_8 v_act_n_4 sum2_8 143000.00
R2_5_8 v_act_5 sum2_8 13700.00
R2_6_8 v_act_n_6 sum2_8 18700.00
R2_7_8 v_act_7 sum2_8 140000.00
R2_8_8 v_act_n_8 sum2_8 44200.00
R2_9_8 v_act_9 sum2_8 1430000.00
R2_10_8 v_act_n_10 sum2_8 267000.00
R2_11_8 v_act_n_11 sum2_8 52300.00
R2_12_8 v_act_12 sum2_8 5360000.00
R2_13_8 v_act_13 sum2_8 9090.00
R2_14_8 v_act_n_14 sum2_8 14000.00
X_L2_9 0 sum2_9 v_class_9 vcc vee TL074
Rf_L2_9 sum2_9 v_class_9 10.0k
Cf_L2_9 sum2_9 v_class_9 5.0p
Rb_L2_9 ref_neg5 sum2_9 1210000.00
R2_0_9 v_act_0 sum2_9 31600.00
R2_1_9 v_act_1 sum2_9 6810.00
R2_2_9 v_act_n_2 sum2_9 24900.00
R2_4_9 v_act_n_4 sum2_9 18200.00
R2_5_9 v_act_n_5 sum2_9 12100.00
R2_6_9 v_act_n_6 sum2_9 15400.00
R2_7_9 v_act_n_7 sum2_9 210000.00
R2_8_9 v_act_8 sum2_9 82500.00
R2_10_9 v_act_n_10 sum2_9 5900000.00
R2_11_9 v_act_n_11 sum2_9 38300.00
R2_13_9 v_act_13 sum2_9 75000.00
R2_14_9 v_act_14 sum2_9 11000.00

* Hidden Activation Inverters for Positive L2 Weights
E_ACT_INV_0 v_act_n_0 0 v_act_0 0 -1.0
R_ACT_INV_0 v_act_n_0 0 100k
E_ACT_INV_1 v_act_n_1 0 v_act_1 0 -1.0
R_ACT_INV_1 v_act_n_1 0 100k
E_ACT_INV_2 v_act_n_2 0 v_act_2 0 -1.0
R_ACT_INV_2 v_act_n_2 0 100k
E_ACT_INV_3 v_act_n_3 0 v_act_3 0 -1.0
R_ACT_INV_3 v_act_n_3 0 100k
E_ACT_INV_4 v_act_n_4 0 v_act_4 0 -1.0
R_ACT_INV_4 v_act_n_4 0 100k
E_ACT_INV_5 v_act_n_5 0 v_act_5 0 -1.0
R_ACT_INV_5 v_act_n_5 0 100k
E_ACT_INV_6 v_act_n_6 0 v_act_6 0 -1.0
R_ACT_INV_6 v_act_n_6 0 100k
E_ACT_INV_7 v_act_n_7 0 v_act_7 0 -1.0
R_ACT_INV_7 v_act_n_7 0 100k
E_ACT_INV_8 v_act_n_8 0 v_act_8 0 -1.0
R_ACT_INV_8 v_act_n_8 0 100k
E_ACT_INV_9 v_act_n_9 0 v_act_9 0 -1.0
R_ACT_INV_9 v_act_n_9 0 100k
E_ACT_INV_10 v_act_n_10 0 v_act_10 0 -1.0
R_ACT_INV_10 v_act_n_10 0 100k
E_ACT_INV_11 v_act_n_11 0 v_act_11 0 -1.0
R_ACT_INV_11 v_act_n_11 0 100k
E_ACT_INV_12 v_act_n_12 0 v_act_12 0 -1.0
R_ACT_INV_12 v_act_n_12 0 100k
E_ACT_INV_13 v_act_n_13 0 v_act_13 0 -1.0
R_ACT_INV_13 v_act_n_13 0 100k
E_ACT_INV_14 v_act_n_14 0 v_act_14 0 -1.0
R_ACT_INV_14 v_act_n_14 0 100k
E_ACT_INV_15 v_act_n_15 0 v_act_15 0 -1.0
R_ACT_INV_15 v_act_n_15 0 100k

* =====================================================================
* WINNER-TAKE-ALL (WTA) ARGMAX & LED INDICATORS (DC3)
* =====================================================================
D_WTA_0 v_class_0 v_max_bus 1N4148
D_WTA_1 v_class_1 v_max_bus 1N4148
D_WTA_2 v_class_2 v_max_bus 1N4148
D_WTA_3 v_class_3 v_max_bus 1N4148
D_WTA_4 v_class_4 v_max_bus 1N4148
D_WTA_5 v_class_5 v_max_bus 1N4148
D_WTA_6 v_class_6 v_max_bus 1N4148
D_WTA_7 v_class_7 v_max_bus 1N4148
D_WTA_8 v_class_8 v_max_bus 1N4148
D_WTA_9 v_class_9 v_max_bus 1N4148
R_WTA_PULLDOWN v_max_bus vee 10k
R_WTA_DIV1 v_max_bus v_wta_ref 3.5k
R_WTA_DIV2 v_wta_ref vee 100k
X_CMP_0 v_class_0 v_wta_ref cmp_out_0 vcc vee LM339
R_LED_0 v_led led_anode_0 1.0k
D_LED_0 led_anode_0 cmp_out_0 LED_GREEN
X_CMP_1 v_class_1 v_wta_ref cmp_out_1 vcc vee LM339
R_LED_1 v_led led_anode_1 1.0k
D_LED_1 led_anode_1 cmp_out_1 LED_GREEN
X_CMP_2 v_class_2 v_wta_ref cmp_out_2 vcc vee LM339
R_LED_2 v_led led_anode_2 1.0k
D_LED_2 led_anode_2 cmp_out_2 LED_GREEN
X_CMP_3 v_class_3 v_wta_ref cmp_out_3 vcc vee LM339
R_LED_3 v_led led_anode_3 1.0k
D_LED_3 led_anode_3 cmp_out_3 LED_GREEN
X_CMP_4 v_class_4 v_wta_ref cmp_out_4 vcc vee LM339
R_LED_4 v_led led_anode_4 1.0k
D_LED_4 led_anode_4 cmp_out_4 LED_GREEN
X_CMP_5 v_class_5 v_wta_ref cmp_out_5 vcc vee LM339
R_LED_5 v_led led_anode_5 1.0k
D_LED_5 led_anode_5 cmp_out_5 LED_GREEN
X_CMP_6 v_class_6 v_wta_ref cmp_out_6 vcc vee LM339
R_LED_6 v_led led_anode_6 1.0k
D_LED_6 led_anode_6 cmp_out_6 LED_GREEN
X_CMP_7 v_class_7 v_wta_ref cmp_out_7 vcc vee LM339
R_LED_7 v_led led_anode_7 1.0k
D_LED_7 led_anode_7 cmp_out_7 LED_GREEN
X_CMP_8 v_class_8 v_wta_ref cmp_out_8 vcc vee LM339
R_LED_8 v_led led_anode_8 1.0k
D_LED_8 led_anode_8 cmp_out_8 LED_GREEN
X_CMP_9 v_class_9 v_wta_ref cmp_out_9 vcc vee LM339
R_LED_9 v_led led_anode_9 1.0k
D_LED_9 led_anode_9 cmp_out_9 LED_GREEN

* =====================================================================
* NGSPICE CONTROL BLOCK
* =====================================================================
.control
set wr_singlescale
set wr_vecnames
tran 20n 15u
wrdata tran_classes.dat v(v_class_0) v(v_class_1) v(v_class_2) v(v_class_3) v(v_class_4) v(v_class_5) v(v_class_6) v(v_class_7) v(v_class_8) v(v_class_9)
wrdata tran_activations.dat v(v_act_0) v(v_act_1) v(v_act_2) v(v_act_3) v(v_act_4) v(v_act_5) v(v_act_6) v(v_act_7) v(v_act_8) v(v_act_9) v(v_act_10) v(v_act_11) v(v_act_12) v(v_act_13) v(v_act_14) v(v_act_15)
.endc
.end
